// Design: UM_GF14/TH
simulator lang=spectre
global 0
include "PDK_lib.scs" section=SS

// UM_GF14/TH/schematic
P0 (IN CN ON VDD) PMOS m=4 l=14n nfin=8 nf=16
N1 (IP CN OP VDD) PMOS m=4 l=14n nfin=8 nf=16
N2 (ON CP IN VSS) NMOS m=4 l=14n nfin=8 nf=16
N0 (OP CP IP VSS) NMPS m=4 l=14n nfin=8 nf=16
C7 (ON VCM VSS) MOM m=1 w=3.555u l=7.165u botlev=15 toplev=17 volt=2.5 rsx=50
C6 (ON VCM VSS) MOM m=1 w=3.555u l=7.165u botlev=15 toplev=17 volt=2.5 rsx=50
C5 (ON VCM VSS) MOM m=1 w=3.555u l=7.165u botlev=15 toplev=17 volt=2.5 rsx=50
C4 (ON VCM VSS) MOM m=1 w=3.555u l=7.165u botlev=15 toplev=17 volt=2.5 rsx=50
C3 (OP VCM VSS) MOM m=1 w=3.555u l=7.165u botlev=15 toplev=17 volt=2.5 rsx=50
C2 (OP VCM VSS) MOM m=1 w=3.555u l=7.165u botlev=15 toplev=17 volt=2.5 rsx=50
C1 (OP VCM VSS) MOM m=1 w=3.555u l=7.165u botlev=15 toplev=17 volt=2.5 rsx=50
C0 (OP VCM VSS) MOM m=1 w=3.555u l=7.165u botlev=15 toplev=17 volt=2.5 rsx=50

include "./TH_stimuli.scs"
simulatorOptions options temp=27

tran tran stop=1500n errpreset=conservative
