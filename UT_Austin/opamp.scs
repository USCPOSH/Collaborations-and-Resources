// Design: UM_GF14/TB_IBS_norm
simulator lang=spectre
global 0
include "PDK_lib.scs" section=SS

// UM_GF14/IBS_norm_rvt/schematic
subckt IBS_norm_rvt IBS_IN IBSn_OUT IBSp_OUT VDD VSS
    N2 (IBSn_OUT net7 VSS VSS) NMOS m=4 l=14n nfin=3 nf=4
    N1 (net7 net7 VSS VSS) NMOS m=1 l=14n nfin=3 nf=4
    P2 (IBSp_OUT IBS_IN VDD VDD) NMOS m=4 l=16n nfin=3 nf=4
    P1 (IBS_IN IBS_IN VDD VDD) NMOS m=1 l=14n nfin=3 nf=4
    P0 (net7 IBS_IN VDD VDD) NMOS m=1 l=14n nfin=3 nf=4
ends IBS_norm_rvt

// UM_GF14/Amp_diff_norm_rvt/schematic
subckt Amp_diff_norm_rvt IBSn IN IP ON OP VDD VSS
    R9 (OP VDD VDD) resistor r=3.83529K
    R0 (ON VDD VDD) resistor r=3.83529K
    N3 (IBSn IBSn VSS VSS) NMOS m=4 l=14n nfin=3 nf=4
    N2 (OP IN net39 VSS) NMOS m=2 l=14n nfin=3 nf=4
    N1 (ON IP net39 VSS) NMOS m=2 l=14n nfin=3 nf=4
    N0 (net39 IBSn VSS VSS) NMOS m=4 l=14n nfin=3 nf=4
ends Amp_diff_norm_rvt

// UM_GF14/TB_IBS_norm/schematic
I34 (net021 net038 net022 VDD 0) IBS_norm_rvt
I35 (net021 0) isource dc=20u type=dc

V8 (net019 0) vsource dc=600.0m mag=-500m type=dc
V7 (net020 0) vsource dc=600.0m mag=500m type=dc
V0 (VDD 0) vsource dc=800.0m type=dc
I37 (net022 net019 net020 rON rOP VDD 0) Amp_diff_norm_rvt

simulatorOptions options temp=27
dcOp dc
ac ac start=1k stop=100G
